** sch_path: /home/safal/projects/GitHub_CMOS_4bit_ALU/AllSymbols&Sch/GenericSym/TransmissionGate.sch
**.subckt Xs_TransmissionGate X VP A Y VN X'
*.ipin A
*.opin Y
*.ipin X'
*.ipin X
*.iopin VP
*.iopin VN
XM1 A X Y VP sky130_fd_pr__pfet_01v8 L=0.15 W=1 nf=1 ad=0.29 as=0.29 pd=2.58 ps=2.58 nrd=0.29 nrs=0.29 sa=0 sb=0 sd=0 mult=1 m=1
XM2 A X' Y VN sky130_fd_pr__nfet_01v8 L=0.15 W=1 nf=1 ad=0.29 as=0.29 pd=2.58 ps=2.58 nrd=0.29 nrs=0.29 sa=0 sb=0 sd=0 mult=1 m=1
**** begin user architecture code

**** end user architecture code
**.ends
.end
